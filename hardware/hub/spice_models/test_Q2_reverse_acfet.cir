* Q2 reverse-polarity check, extended to the ACFET/RBFET pair Q303/Q304 behind VDC.
* Q2 uses the Diodes DMP3098L model; Q303/Q304 use AO3400.mod (AOS-format AO3400 model, see
* README.md for where it comes from). Subckt pin orders: DMP3098L = drain gate source,
* AO3400 = drain gate source.
* Question: when VDC is pulled negative, does the common-source node MUX2_MID follow it, and what
* gate-to-source voltage does that put on Q303/Q304 (AO3400A is rated +/-12 V)?
.include DMP3098L.spice.txt
.include AO3400.mod
.model DZ12 D (IS=1e-14 BV=12 IBV=5m RS=5)

V1 in 0 DC -24
* Q2 as built: source at CN5 (in), drain at VDC
X1 vdc g in DMP3098L
R19 g 0 100k
D2 g in DZ12
C28 vdc 0 100n
* Q303: drain VDC, source MUX2_MID. Q304: drain VBUS_INTERNAL, source MUX2_MID. Gates on ACDRV2.
X303 vdc acdrv mid AO3400
X304 vbus acdrv mid AO3400
* ACDRV2 held near ground by the charger (modelled as 1 Meg to GND)
RACDRV acdrv 0 1Meg
* VBUS_INTERNAL: bulk caps, plus a light load to GND standing in for the charger's VBUS pin
CVBUS vbus 0 20u
RVBUS vbus 0 100k

.control
tran 10u 20m
meas tran vdc_end find v(vdc) at=20m
meas tran mid_end find v(mid) at=20m
meas tran acdrv_end find v(acdrv) at=20m
meas tran vbus_end find v(vbus) at=20m
quit
.endc

.end
