* Q1 (MDD3415) battery reverse-polarity check, as now wired: drain at J4 (VBAT_RAW), source at
* VBAT_PROTECTED, gate to GND through R17. MDD3415 has no published SPICE model, so this uses a
* GENERIC PMOS sized to the datasheet (Vth about -0.7 V, about 37 mOhm at Vgs = -4.5 V, body diode
* drain to source). Treat the numbers as indicative.
.model PMDD PMOS (LEVEL=1 VTO=-0.7 KP=7 LAMBDA=0.01 IS=1e-12 RD=0.005 RS=0.005)
.model DPIN D (IS=1e-14 RS=0.5)

.subckt q1fix raw vbp
M1 raw g vbp vbp PMDD W=1 L=1
R17 g 0 100k
.ends

* ---- Discharge: 3.7 V battery on J4, 2 A load on VBAT_PROTECTED ----
VD rawD 0 DC 3.7
XD rawD vbpD q1fix
RLD vbpD 0 1.85

* ---- Charge: charger drives VBAT_PROTECTED at 4.2 V into a 3.7 V cell (0.1 ohm) ----
VC vbpC 0 DC 4.2
XC rawC vbpC q1fix
RCELL rawC cell 0.1
VCELL cell 0 DC 3.7

* ---- Reversed battery: J4 pin 1 at -4.2 V, board loads on VBAT_PROTECTED ----
VR rawR 0 DC -4.2
XR rawR vbpR q1fix
RGAUGE vbpR 0 110k
DGAUGE 0 vbpR DPIN
R304 vbpR batp 100
DBATP 0 batp DPIN
C401 vbpR 0 100n

.control
tran 10u 5m
meas tran dis_vbp find v(vbpD) at=5m
meas tran chg_icell find i(VCELL) at=5m
meas tran rev_vbp find v(vbpR) at=5m
meas tran rev_iin find i(VR) at=5m
quit
.endc

.end
