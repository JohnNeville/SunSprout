* Q1 (MDD3415, real part) tested against AO3415 (AOSMD) as a spec-equivalent stand-in
.include AO3415_clean.mod

VDD vdd 0 DC 3.3
X1 VBAT __unnamed_15 vdd AO3415
RLOAD VBAT 0 1k
Vgate __unnamed_15 0 DC 3.3

.control
dc Vgate 0 3.3 0.01
let id = i(VDD)
let absid = abs(id)
meas dc vth when absid=1m
let i_on = vecmax(absid)
print vth
print i_on
.endc

.end
